* NGSPICE file created from gate_not_x1.ext - technology: sky130A

.subckt gate_not_x1 in out VDDA VSSA
X0 out.t0 in.t0 VSSA.t1 VSSA.t0 sky130_fd_pr__nfet_01v8 ad=0.25 pd=2 as=0.25 ps=2 w=0.5 l=0.15
X1 out.t1 in.t1 VDDA.t1 VDDA.t0 sky130_fd_pr__pfet_01v8 ad=0.75 pd=4 as=0.75 ps=4 w=1.5 l=0.15
R0 out.n0 out.t0 265.8
R1 out.n0 out.t1 263.704
R2 out out.n0 16.0005
R3 in.n0 in.t1 387.062
R4 in in.n0 209.601
R5 in.n0 in.t0 162.127
R6 VDDA.n9 VDDA.n8 585
R7 VDDA.n4 VDDA.t0 391.875
R8 VDDA.n8 VDDA.n7 290.733
R9 VDDA.n6 VDDA.n5 230.308
R10 VDDA.n3 VDDA.n1 185
R11 VDDA.n9 VDDA.n2 185
R12 VDDA.n4 VDDA.n2 185
R13 VDDA.n3 VDDA.n2 120.001
R14 VDDA.n5 VDDA.n4 69.8479
R15 VDDA.n5 VDDA.n3 45.3071
R16 VDDA.n8 VDDA.t1 32.8338
R17 VDDA.n6 VDDA.n0 9.33099
R18 VDDA VDDA.n9 9.31879
R19 VDDA.n1 VDDA.n0 9.3005
R20 VDDA.n9 VDDA.n1 7.11161
R21 VDDA.n7 VDDA.n6 3.53508
R22 VDDA.n7 VDDA.n1 3.53508
R23 VDDA VDDA.n0 0.0126951
R24 VSSA.n0 VSSA.t0 3681.45
R25 VSSA.n0 VSSA.t1 253
R26 VSSA VSSA.n0 9.4755
C0 out VDDA 0.24113f
C1 out in 0.06594f
C2 in VDDA 0.14601f
C3 out VSSA 0.27722f
C4 in VSSA 0.39615f
C5 VDDA VSSA 0.88385f
C6 VDDA.n0 VSSA 0.06513f
C7 VDDA.n1 VSSA 0.0179f
C8 VDDA.t0 VSSA 0.0945f
C9 VDDA.n4 VSSA 0.06863f
C10 VDDA.n6 VSSA 0.01819f
C11 VDDA.n8 VSSA 0.02238f
C12 VDDA.n9 VSSA 0.01617f
C13 in.t1 VSSA 0.04267f
C14 in.t0 VSSA 0.01239f
C15 in.n0 VSSA 0.09411f
C16 out.t1 VSSA 0.10637f
C17 out.t0 VSSA 0.03114f
C18 out.n0 VSSA 0.16609f
.ends
